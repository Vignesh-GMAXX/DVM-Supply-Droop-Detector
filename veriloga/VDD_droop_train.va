`include "constants.vams"
`include "disciplines.vams"

// VDD_droop_train (v4, exact depths): six smooth supply droops of different
// depth and shape in one run. Each droop is a rounded "U" whose deepest point
// is EXACTLY the nominal depth (5/10/15%), and whose bottom stays within 1% of
// that depth for >= 4.5 ns (about two DVM samples), like a static droop.
//
// Event i:  d_i(t) = a_i * exp( -0.5 * ((t - c_i)/w)^4 ),
//           w = wf_i before the centre (fall side), w = wr_i after (recovery side)
//   a_i : depth in V (0.10 = 10% of 1.0 V) -- also the peak depth
//   c_i : time of the deepest point
//   time within 1% of a_i = 0.3765*(wf_i + wr_i)
//
// Default events (stop time 206 ns):
//   E1 c= 20.5 ns  5%  symmetric  (wf 6.0, wr 6.0)  held 4.5 ns  window  10- 35 ns
//   E2 c= 47.3 ns 10%  fast fall  (wf 4.2, wr 7.8)  held 4.5 ns  window  35- 65 ns
//   E3 c= 83.8 ns 10%  wide       (wf 8.0, wr 8.0)  held 6.0 ns  window  65-102 ns
//   E4 c=113.0 ns 15%  fast fall  (wf 3.6, wr 8.4)  held 4.5 ns  window 102-132 ns
//   E5 c=148.1 ns 15%  symmetric  (wf 6.6, wr 6.6)  held 5.0 ns  window 132-164 ns
//   E6 c=184.8 ns  5%  wide       (wf 9.3, wr 9.3)  held 7.0 ns  window 164-206 ns

module VDD_droop_train(vout);
  output vout;
  electrical vout;

  parameter real vnom = 1.0;

  parameter real c1 = 20.5n;  parameter real a1 = 0.05; parameter real wf1 = 6.0n; parameter real wr1 = 6.0n;
  parameter real c2 = 47.3n;  parameter real a2 = 0.10; parameter real wf2 = 4.2n; parameter real wr2 = 7.8n;
  parameter real c3 = 83.8n;  parameter real a3 = 0.10; parameter real wf3 = 8.0n; parameter real wr3 = 8.0n;
  parameter real c4 = 113.0n; parameter real a4 = 0.15; parameter real wf4 = 3.6n; parameter real wr4 = 8.4n;
  parameter real c5 = 148.1n; parameter real a5 = 0.15; parameter real wf5 = 6.6n; parameter real wr5 = 6.6n;
  parameter real c6 = 184.8n; parameter real a6 = 0.05; parameter real wf6 = 9.3n; parameter real wr6 = 9.3n;

  parameter real hstep = 20p;   // max time step while a droop is present

  real t, d;
  integer active;

  // rounded dip (0..1), exactly 1 at the centre
  analog function real ushape;
    input tt, c, wf, wr;
    real tt, c, wf, wr, x;
    begin
      x = (tt < c) ? (c - tt)/wf : (tt - c)/wr;
      if (x > 3.0) ushape = 0.0;
      else         ushape = exp(-0.5*x*x*x*x);
    end
  endfunction

  // 1 while the event is non-negligible
  analog function integer near;
    input tt, c, wf, wr;
    real tt, c, wf, wr;
    begin
      near = (tt > c - 2.0*wf && tt < c + 2.0*wr) ? 1 : 0;
    end
  endfunction

  analog begin
    t = $abstime;

    // breakpoints at the start of each event so the step size tightens in time
    @(timer(c1 - 2.0*wf1) or timer(c2 - 2.0*wf2) or timer(c3 - 2.0*wf3) or
      timer(c4 - 2.0*wf4) or timer(c5 - 2.0*wf5) or timer(c6 - 2.0*wf6)) ;

    d = a1*ushape(t, c1, wf1, wr1) + a2*ushape(t, c2, wf2, wr2)
      + a3*ushape(t, c3, wf3, wr3) + a4*ushape(t, c4, wf4, wr4)
      + a5*ushape(t, c5, wf5, wr5) + a6*ushape(t, c6, wf6, wr6);

    active = near(t, c1, wf1, wr1) + near(t, c2, wf2, wr2) + near(t, c3, wf3, wr3)
           + near(t, c4, wf4, wr4) + near(t, c5, wf5, wr5) + near(t, c6, wf6, wr6);
    if (active > 0) $bound_step(hstep);

    V(vout) <+ vnom - d;
  end
endmodule
